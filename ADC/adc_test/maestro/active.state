ADE simulation setup
Test ADC_adc_test_1: ADC/adc_test/schematic, simulator spectre
  Models: /home/vi42/SKY130_PDK/sky130_release/libs/sky130_fd_pr_main/../../models/sky130.lib.spice[tt]
  Temperature: 27
  Stimulus in_p: voltage dc dc=1.2 srcType=dc
  Stimulus in_n: voltage dc dc=643.000m srcType=dc
  Analysis tran: stop=1000n
  Signals: /in_p as vin_p, /b0 as b9, /b1 as b1, /b2 as b2, /b3 as b3, /b4 as b4, /b5 as b5, /b6 as b6, /b7 as b7, /net3 as clk, /in_n as vin_n
Run mode: Single Run, Sweeps and Corners
