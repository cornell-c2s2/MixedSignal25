ADE simulation setup
Run mode: Single Run, Sweeps and Corners
Tests:
  ADC_adc_test_1: ADC/adc_test/schematic, simulator spectre
    Outputs: vin_p; b9; b1; b2; b3; b4; b5; b6; b7; clk; vin_n
